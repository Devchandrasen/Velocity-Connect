# Ansys Electronics Desktop project, version 2025.2
materials:
  vacuum: permittivity=1
  aluminum: permeability=1.000021 conductivity=38000000
  copper: permeability=0.999991 conductivity=58000000
  VC_LowLossRadome: permittivity=1.8 permeability=1 dielectric_loss_tangent=0.001
  PMLGroup1_Z_1: permittivity{anisotropic component1=1.1 component2=1.1 component3=0.45454545} permeability{anisotropic component1=1.1 component2=1.1 component3=0.45454545} dielectric_loss_tangent{anisotropic component1=1 component2=1 component3=-1} magnetic_loss_tangent{anisotropic component1=1 component2=1 component3=-1}
  PMLGroup1_XZ_1: permittivity{anisotropic component1=1 component2=0.01 component3=1} permeability{anisotropic component1=1 component2=0.01 component3=1} dielectric_loss_tangent{anisotropic component1=0 component2=242 component3=0} magnetic_loss_tangent{anisotropic component1=0 component2=242 component3=0}
  PMLGroup1_YZ_1: permittivity{anisotropic component1=0.01 component2=1 component3=1} permeability{anisotropic component1=0.01 component2=1 component3=1} dielectric_loss_tangent{anisotropic component1=242 component2=0 component3=0} magnetic_loss_tangent{anisotropic component1=242 component2=0 component3=0}
  PMLGroup1_XYZ_1: permittivity{anisotropic component1=1.1 component2=1.1 component3=1.1} permeability{anisotropic component1=1.1 component2=1.1 component3=1.1} dielectric_loss_tangent{anisotropic component1=1 component2=1 component3=1} magnetic_loss_tangent{anisotropic component1=1 component2=1 component3=1}

design VC_n78_V2_DualPort (HFSS, HFSS Terminal Network, model units mm)
variables:
  ground_x = 360mm
  ground_y = 180mm
  ground_t = 1mm
  height = 24mm
  top_w = 16mm
  base_w = 22mm
  neck_w = 4mm
  shoulder_h = 5mm
  feed_gap = 0.8mm
  blade_t = 0.5mm
  separation = 160mm
geometry:
  RoofCoupon [aluminum] = box(corner=(-ground_x/2, -ground_y/2, -ground_t), size=(ground_x, ground_y, ground_t))
  Radiator1_SlantMinus [copper] = polyline(xyz in mm: (-80, -2, 0.8) (-83.535534, -11, 4.3355339) (-96.970563, -8, 17.770563) (-96.970563, 8, 17.770563) (-83.535534, 11, 4.3355339) (-80, 2, 0.8) (-80, -2, 0.8), closed, covered)
  Port1_Sheet = polyline(x=-80mm, yz in mm: (-2, 0) (-2, 0.8) (2, 0.8) (2, 0) (-2, 0), closed, covered)
  Radiator2_SlantPlus [copper] = polyline(xyz in mm: (80, -2, 0.8) (83.535534, -11, 4.3355339) (96.970563, -8, 17.770563) (96.970563, 8, 17.770563) (83.535534, 11, 4.3355339) (80, 2, 0.8) (80, -2, 0.8), closed, covered)
  Port2_Sheet = polyline(x=80mm, yz in mm: (-2, 0) (-2, 0.8) (2, 0.8) (2, 0) (-2, 0), closed, covered)
  RadomeShell_Port1 [VC_LowLossRadome] = box(corner=(-107mm, -27mm, 0mm), size=(54mm, 54mm, 40mm))
  RadomeShell_Port1_InteriorTool = box(corner=(-106mm, -26mm, 0mm), size=(52mm, 52mm, 39mm))
  RadomeShell_Port1.subtract(RadomeShell_Port1_InteriorTool)
  RadomeShell_Port2 [VC_LowLossRadome] = box(corner=(53mm, -27mm, 0mm), size=(54mm, 54mm, 40mm))
  RadomeShell_Port2_InteriorTool = box(corner=(54mm, -26mm, 0mm), size=(52mm, 52mm, 39mm))
  RadomeShell_Port2.subtract(RadomeShell_Port2_InteriorTool)
  RadiatingSurface [vacuum] = region(absolute_offset=22.727273mm on all sides)
  coordinate_system FaceCS1 = face of RadiatingSurface: Origin=(202.72727, -112.72727, 62.727273) FaceID=RadiatingSurface.face(+z) AxisPosn=(202.72727, 112.72727, 62.727273) WhichAxis=X ZRotationAngle=0deg XOffset=0mm YOffset=0mm FaceNormal(0, 0, 1)
  PML_RadiatingSurface_1 [PMLGroup1_Z_1, oriented by FaceCS1] = sweep_along_normal(RadiatingSurface.face(+z), length=104.86353mm)
  coordinate_system FaceCS2 = face of RadiatingSurface: Origin=(202.72727, -112.72727, -23.727273) FaceID=RadiatingSurface.face(-z) AxisPosn=(-202.72727, -112.72727, -23.727273) WhichAxis=X ZRotationAngle=0deg XOffset=0mm YOffset=0mm FaceNormal(0, 0, -1)
  PML_RadiatingSurface_2 [PMLGroup1_Z_1, oriented by FaceCS2] = sweep_along_normal(RadiatingSurface.face(-z), length=104.86353mm)
  coordinate_system FaceCS3 = face of RadiatingSurface: Origin=(202.72727, -112.72727, 62.727273) FaceID=RadiatingSurface.face(-y) AxisPosn=(-202.72727, -112.72727, 62.727273) WhichAxis=X ZRotationAngle=0deg XOffset=0mm YOffset=0mm FaceNormal(0, -1, 0)
  PML_RadiatingSurface_3 [PMLGroup1_Z_1, oriented by FaceCS3] = sweep_along_normal(RadiatingSurface.face(-y), length=104.86353mm)
  coordinate_system FaceCS4 = face of RadiatingSurface: Origin=(-202.72727, -112.72727, 62.727273) FaceID=RadiatingSurface.face(-x) AxisPosn=(-202.72727, 112.72727, 62.727273) WhichAxis=X ZRotationAngle=0deg XOffset=0mm YOffset=0mm FaceNormal(-1, 0, 0)
  PML_RadiatingSurface_4 [PMLGroup1_Z_1, oriented by FaceCS4] = sweep_along_normal(RadiatingSurface.face(-x), length=104.86353mm)
  coordinate_system FaceCS5 = face of RadiatingSurface: Origin=(-202.72727, 112.72727, 62.727273) FaceID=RadiatingSurface.face(+y) AxisPosn=(202.72727, 112.72727, 62.727273) WhichAxis=X ZRotationAngle=0deg XOffset=0mm YOffset=0mm FaceNormal(0, 1, 0)
  PML_RadiatingSurface_5 [PMLGroup1_Z_1, oriented by FaceCS5] = sweep_along_normal(RadiatingSurface.face(+y), length=104.86353mm)
  coordinate_system FaceCS6 = face of RadiatingSurface: Origin=(202.72727, 112.72727, -23.727273) FaceID=RadiatingSurface.face(+x) AxisPosn=(202.72727, 112.72727, 62.727273) WhichAxis=X ZRotationAngle=0deg XOffset=0mm YOffset=0mm FaceNormal(1, 0, 0)
  PML_RadiatingSurface_6 [PMLGroup1_Z_1, oriented by FaceCS6] = sweep_along_normal(RadiatingSurface.face(+x), length=104.86353mm)
  PML_RadiatingSurface_7 [PMLGroup1_XZ_1, oriented by FaceCS1] = sweep_along_normal(PML_RadiatingSurface_1.face(at (0, -112.727, 115.159)), length=104.86353mm)
  PML_RadiatingSurface_8 [PMLGroup1_YZ_1, oriented by FaceCS4] = sweep_along_normal(PML_RadiatingSurface_1.face(at (-202.727, 0, 115.159)), length=104.86353mm)
  PML_RadiatingSurface_9 [PMLGroup1_YZ_1, oriented by FaceCS5] = sweep_along_normal(PML_RadiatingSurface_1.face(at (0, 112.727, 115.159)), length=104.86353mm)
  PML_RadiatingSurface_10 [PMLGroup1_YZ_1, oriented by FaceCS1] = sweep_along_normal(PML_RadiatingSurface_1.face(at (202.727, 0, 115.159)), length=104.86353mm)
  PML_RadiatingSurface_11 [PMLGroup1_YZ_1, oriented by FaceCS2] = sweep_along_normal(PML_RadiatingSurface_2.face(at (0, -112.727, -76.159)), length=104.86353mm)
  coordinate_system FaceCS7 = face of RadiatingSurface: Origin=(-202.72727, -112.72727, -23.727273) FaceID=RadiatingSurface.face(-z) AxisPosn=(-202.72727, 112.72727, -23.727273) WhichAxis=X ZRotationAngle=0deg XOffset=0mm YOffset=0mm FaceNormal(0, 0, -1)
  PML_RadiatingSurface_12 [PMLGroup1_YZ_1, oriented by FaceCS7] = sweep_along_normal(PML_RadiatingSurface_2.face(at (-202.727, 0, -76.159)), length=104.86353mm)
  coordinate_system FaceCS8 = face of RadiatingSurface: Origin=(-202.72727, 112.72727, -23.727273) FaceID=RadiatingSurface.face(-z) AxisPosn=(202.72727, 112.72727, -23.727273) WhichAxis=X ZRotationAngle=0deg XOffset=0mm YOffset=0mm FaceNormal(0, 0, -1)
  PML_RadiatingSurface_13 [PMLGroup1_YZ_1, oriented by FaceCS8] = sweep_along_normal(PML_RadiatingSurface_2.face(at (0, 112.727, -76.159)), length=104.86353mm)
  PML_RadiatingSurface_14 [PMLGroup1_XZ_1, oriented by FaceCS2] = sweep_along_normal(PML_RadiatingSurface_2.face(at (202.727, 0, -76.159)), length=104.86353mm)
  PML_RadiatingSurface_15 [PMLGroup1_XZ_1, oriented by FaceCS4] = sweep_along_normal(PML_RadiatingSurface_3.face(at (-202.727, -165.159, 19.5)), length=104.86353mm)
  PML_RadiatingSurface_16 [PMLGroup1_XZ_1, oriented by FaceCS3] = sweep_along_normal(PML_RadiatingSurface_3.face(at (202.727, -165.159, 19.5)), length=104.86353mm)
  PML_RadiatingSurface_17 [PMLGroup1_XZ_1, oriented by FaceCS5] = sweep_along_normal(PML_RadiatingSurface_4.face(at (-255.159, 112.727, 19.5)), length=104.86353mm)
  PML_RadiatingSurface_18 [PMLGroup1_YZ_1, oriented by FaceCS6] = sweep_along_normal(PML_RadiatingSurface_5.face(at (202.727, 165.159, 19.5)), length=104.86353mm)
  PML_RadiatingSurface_19 [PMLGroup1_XYZ_1, oriented by FaceCS4] = sweep_along_normal(PML_RadiatingSurface_7.face(at (-202.727, -165.159, 115.159)), length=104.86353mm)
  PML_RadiatingSurface_20 [PMLGroup1_XYZ_1, oriented by FaceCS1] = sweep_along_normal(PML_RadiatingSurface_7.face(at (202.727, -165.159, 115.159)), length=104.86353mm)
  PML_RadiatingSurface_21 [PMLGroup1_XYZ_1, oriented by FaceCS5] = sweep_along_normal(PML_RadiatingSurface_8.face(at (-255.159, 112.727, 115.159)), length=104.86353mm)
  coordinate_system FaceCS9 = face of RadiatingSurface: Origin=(202.72727, 112.72727, 62.727273) FaceID=RadiatingSurface.face(+z) AxisPosn=(-202.72727, 112.72727, 62.727273) WhichAxis=X ZRotationAngle=0deg XOffset=0mm YOffset=0mm FaceNormal(0, 0, 1)
  PML_RadiatingSurface_22 [PMLGroup1_XYZ_1, oriented by FaceCS9] = sweep_along_normal(PML_RadiatingSurface_9.face(at (202.727, 165.159, 115.159)), length=104.86353mm)
  PML_RadiatingSurface_23 [PMLGroup1_XYZ_1, oriented by FaceCS7] = sweep_along_normal(PML_RadiatingSurface_11.face(at (-202.727, -165.159, -76.159)), length=104.86353mm)
  PML_RadiatingSurface_24 [PMLGroup1_XYZ_1, oriented by FaceCS2] = sweep_along_normal(PML_RadiatingSurface_11.face(at (202.727, -165.159, -76.159)), length=104.86353mm)
  PML_RadiatingSurface_25 [PMLGroup1_XYZ_1, oriented by FaceCS8] = sweep_along_normal(PML_RadiatingSurface_12.face(at (-255.159, 112.727, -76.159)), length=104.86353mm)
  PML_RadiatingSurface_26 [PMLGroup1_XYZ_1, oriented by FaceCS6] = sweep_along_normal(PML_RadiatingSurface_13.face(at (202.727, 165.159, -76.159)), length=104.86353mm)
  group PMLGroup1 = PML_RadiatingSurface_1..PML_RadiatingSurface_26
boundaries and excitations:
  FiniteCond_Radiator1_SlantMinus: Finite Conductivity Objects=Radiator1_SlantMinus UseMaterial Material=copper Thickness=blade_t Roughness=2um IsTwoSided
  FiniteCond_Radiator2_SlantPlus: Finite Conductivity Objects=Radiator2_SlantPlus UseMaterial Material=copper Thickness=blade_t Roughness=2um IsTwoSided
  PML_radiation1: Radiation Faces=RadiatingSurface.face(+z) IsForPML
  PML_radiation2: Radiation Faces=RadiatingSurface.face(-z) IsForPML
  PML_radiation3: Radiation Faces=RadiatingSurface.face(-y) IsForPML
  PML_radiation4: Radiation Faces=RadiatingSurface.face(-x) IsForPML
  PML_radiation5: Radiation Faces=RadiatingSurface.face(+y) IsForPML
  PML_radiation6: Radiation Faces=RadiatingSurface.face(+x) IsForPML
  Port1_T1: Terminal port=Port1 Edges=Radiator1_SlantMinus.edge(at (-80, 0, 0.8)) TerminalResistance=50ohm
  Port2_T1: Terminal port=Port2 Edges=Radiator2_SlantPlus.edge(at (80, 0, 0.8)) TerminalResistance=50ohm
  Port1: Lumped Port Faces=Port1_Sheet.face LumpedPortType=Terminal Impedance=50ohm
  Port2: Lumped Port Faces=Port2_Sheet.face LumpedPortType=Terminal Impedance=50ohm
  reference conductors: RoofCoupon
mesh:
  AbsorbingBoundaryAccuracy: LengthBased Faces=RadiatingSurface.face(all 6) MaxLength=30mm
setups:
  Setup_V2_Dual: HfssDriven Frequency=3.55GHz MaxDeltaS=0.01 MaximumPasses=9 MinimumPasses=3 MinimumConvergedPasses=1 PercentRefinement=15 BasisOrder=1 PortAccuracy=4 DrivenSolverType="Direct Solver"
    sweep Sweep_V2_Dual: 3.3GHz to 3.8GHz step 0.025GHz; Type=Interpolating InterpTolerance=0.5 InterpMaxSolns=250 InterpUsePortImped=false PassivityErrorTolerance=0.0001
source amplitudes:
  Port1:1: 1V 0deg
  Port2:1: 0V 0deg
radiation setups:
  3D: Infinite Sphere Theta=0deg..180deg step 2deg Phi=-180deg..180deg step 2deg
  Elevation: Infinite Sphere Theta=-180deg..180deg step 1deg Phi=0deg..90deg step 90deg
  Azimuth: Infinite Sphere Theta=90deg..90deg step 0deg Phi=-180deg..180deg step 1deg
  FFSphere_V2_Dual: Infinite Sphere Theta=0deg..180deg step 5deg Phi=0deg..360deg step 5deg
